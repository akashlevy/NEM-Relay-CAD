// Spectre netlist example of a MEMS reference oscillator based on a Verilog-A
// large-signal model of a fixed-fixed beam RF MEMS resonator
//
// K. Van Caekenberghe (vcaeken@umich.edu)
// Check for update: http://www-personal.umich.edu/~vcaeken
// Updated 02-August-2013 by David Chou (chou@synopsys.com):
//   1. Added kick start PWL vsource.
//   2. For stand-alone, command-line Spectre, added the "ahdl_include".
//   3. Tightened maxstep to 5n for smoother waveform.
//   4. Added blowup value to prevent simulation stoppage by hitting default
//      1G V value for dVindt during Verilog-A evaluation.
//   5. Added save=all to simulatorOptions.

ahdl_include "FIXED_FIXED_BEAM_RF_MEMS_RESONATOR.va"

R0 (out net08) resistor r=1 isnoisy=yes
VOUT (net08 0) vsource type=dc dc=0
VIN (in n1) vsource type=pwl wave=[0 1 1n 0]
H1 (n1 0) ccvs rm=10G type=ccvs min=-0.18 max=0.18 abs=off probe=VOUT
V0 (beam 0) vsource dc=70 type=dc
XRES (in out beam) RF_MEMS_RESONATOR

simulatorOptions options reltol=1e-3 vabstol=1e-6 iabstol=1e-12 temp=27 \
    tnom=27 scalem=1.0 scale=1.0 gmin=1e-12 rforce=1 maxnotes=5 maxwarns=5 \
    digits=5 cols=80 pivrel=1e-3 ckptclock=1800 \
    sensfile="../psf/sens.output" checklimitdest=psf save=all

VoltQuant quantity name="V" blowup=10e9

tran tran stop=1m maxstep=5n write="spectre.ic" writefinal="spectre.fc" \
    annotate=status maxiters=5
//end of file
