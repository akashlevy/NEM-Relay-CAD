// Design: sandbox/cpump_tb
simulator lang=spectre
global 0
include "/tsmc40r/organized_pdk/TSMCHOME/ams/5x1u/TN40CMSP015K3_1_3_2A/tsmcN40/../models/spectre/toplevel.scs" section=top_tt

// sandbox/cpump/schematic
subckt cpump bot in out top
    D0 (top bot) ndio area=1e-10 pj=4e-05 m=1
    D1 (out top) ndio area=1e-10 pj=4e-05 m=1
    C1 (bot out) capacitor c=10p
    C0 (in top) capacitor c=10p
ends cpump

// sandbox/cpump_tb/schematic
I4 (net06 net07 out top) cpump
I3 (net09 net05 net06 net07) cpump
I2 (net04 net03 net09 net05) cpump
I0 (0 net4 net04 net03) cpump
V0 (net4 0) vsource type=pulse val0=0 val1=2.5 period=5n delay=0 rise=100p fall=100p width=2.5n
C0 (out 0) capacitor c=100p
simulatorOptions options temp=27
tran tran stop=1m
save V0:p V0:p
