// ==============================================================
// This is a model of a nano-electro-mechanical relay structure
// designed to implement digital logic. It is a simplified model.
// Model adapted from Kam and Chen. Author: Akash Levy
// ==============================================================

`include "constants.vams"
`include "disciplines.vams"

module nem_relay(d, g, s, b, z);
    inout d;
    electrical d;
    inout g;
    electrical g;
    inout s;
    electrical s;
    inout b;
    electrical b;
    inout z;

// ==================================
// Defining Internal Solver Variables
// ==================================
// NOTE: Pos(z) = downwards displacement
// NOTE: Pos(mbr, z) is height above substrate
// - c - channel voltage
// - mbr - mechanical ground
// - z - position of the relay body (bottom of dielectric spacer)
electrical c;
kinematic mbr, z;

// ==================================================
// Include Technology Parameters and Helper Functions
// ==================================================
`include "tech_params.va"
`include "helper/vafns.va"

// ======================
// Convergence Parameters
// ======================
// Rturnonfrac - fraction of t_gap where air resistance turns off
// Rturnonsharp - sharpness of air resistance turn off function
// cturnonsharp - sharpness of convergence force turn on function
// cturnonval - initial value of convergence force
parameter real Rturnonfrac = 0.95;
parameter real Rturnonsharp = 5e10;
parameter real cturnonsharp = 1e9;
parameter real cturnonval = 1e-10;

// ==============================
// Internal variable declarations
// ==============================
real Qbc, Qdg, Qsg, Qbd, Qbs, Qgb, Qgc;
real Ftot, Fdamp, Fk, Fel, Fcont;

analog begin

// ====================
// Electrical Equations
// ====================
// I(b,c) - body to channel cap
Qbc = V(b,c)*Cbc;
I(b,c)<+ddt(Qbc);

// I(d,g), I(s,g) - drain/source to gate cap
Qdg = V(d,g)*Cgds;
Qsg = V(s,g)*Cgds;
I(d,g)<+ddt(Qdg);
I(s,g)<+ddt(Qsg);

// I(b,d), I(b,s) - body to drain/source variable cap
Qbd = V(b,d)*Cbds*(t_gap + t_sp/K_sp)/(Pos(mbr,z) + t_sp/K_sp);
Qbs = V(b,s)*Cbds*(t_gap + t_sp/K_sp)/(Pos(mbr,z) + t_sp/K_sp);
I(b,d)<+ddt(Qbd);
I(b,s)<+ddt(Qbs);

// I(g,b) - gate to body variable cap
Qgb = V(g,b)*Cgb*(t_gap + t_sp/K_sp)/(Pos(mbr,z) + t_sp/K_sp);
I(g,b)<+ddt(Qgb);

// I(g,c) - gate to channel variable cap
Qgc = V(g,c)*Cgc*(t_gap - t_chan)/(Pos(mbr,z) - t_chan);
I(g,c)<+ddt(Qgc);

// I(d,c), I(s,c) - channel to drain/source variable contact resistance
I(d,c)<+V(d,c)/
    (Rcont + Rair * smoothstep(-(Pos(mbr,z) - t_cont), Rturnonsharp));
I(s,c)<+V(s,c)/
    (Rcont + Rair * smoothstep(-(Pos(mbr,z) - t_cont), Rturnonsharp));

// ===========================================
// F(mbr,z) - Normalized Mechanical Equations
// ===========================================
// Set mbr to mechanical ground
Pos(mbr) <+ t_gap;

// Force Balance Equation
Ftot = meff * ddt(ddt(Pos(z)));
Fdamp = meff * w0/Qf * ddt(Pos(z));
Fk = meff * w0*w0 * Pos(z);
Fel = Qgb * V(g,b) / (2 * (Pos(mbr,z) + t_sp/K_sp));
Fcont = cturnonval*limexp(-cturnonsharp*(Pos(mbr,z) - t_cont));
F(mbr,z) <+ Ftot + Fdamp + Fk - Fel + Fcont;

// DEBUG
$strobe("\nBEGIN");
$strobe("Vgate = %e", V(g));
$strobe("Pos(z) = %e", Pos(z));
$strobe("Pos(mbr,z) = %e", Pos(mbr,z));
$strobe("Ftot = %e", Ftot);
$strobe("Fdamp = %e", Fdamp);
$strobe("Fk = %e", Fk);
$strobe("Fel = %e", Fel);
$strobe("Fcont = %e", Fcont);
$strobe("END");

end
endmodule
