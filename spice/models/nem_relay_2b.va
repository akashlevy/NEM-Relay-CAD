// ==============================================================
// This is a model of a nano-electro-mechanical relay structure
// designed to implement digital logic. It is a simplified model.
// Model adapted from Kam and Chen. Author: Akash Levy
// ==============================================================

`include "constants.vams"
`include "disciplines.vams"

module nem_relay_2b(d0, s0, d1, s1, g, b, z);
    inout d0;
    electrical d0;
    inout s0;
    electrical s0;
    inout d1;
    electrical d1;
    inout s1;
    electrical s1;
    inout g;
    electrical g;
    inout b;
    electrical b;
    inout z;

// ==================================
// Defining Internal Solver Variables
// ==================================
// NOTE: Pos(z) = downwards displacement
// NOTE: Pos(mbr, z) is height above substrate
// - c{n} - channel n voltage
// - mbr - mechanical ground
// - z - position of the relay body (bottom of dielectric spacer)
electrical c0, c1;
kinematic mbr, z;

// ==================================================
// Include Technology Parameters and Helper Functions
// ==================================================
`include "tech_params.va"
`include "helper/vafns.va"

// ======================
// Convergence Parameters
// ======================
// Rturnonfrac - fraction of t_gap where air resistance turns off
// Rturnonsharp - sharpness of air resistance turn off function
// cturnonsharp - sharpness of convergence force turn on function
// cturnonval - initial value of convergence force
parameter real Rturnonfrac = 0.95;
parameter real Rturnonsharp = 5e10;
parameter real cturnonsharp = 1e10;
parameter real cturnonval = 1e-10;

// ==============================
// Internal variable declarations
// ==============================
real Qgb, Qbc0, Qgc0, Qdg0, Qsg0, Qbd0, Qbs0, Qbc1, Qgc1, Qdg1, Qsg1, Qbd1, Qbs1;
real Ftot, Fdamp, Fk, Fel, Fcont;

analog begin

// ====================
// Electrical Equations
// ====================
// I(g,b) - gate to body variable cap
Qgb = V(g,b)*P_EPS0*(L_plate*L_plate - L_cont*L_cont*n_cont*2.5)/(Pos(mbr,z) + t_sp/K_sp);
I(g,b)<+ddt(Qgb);

// I(b,c0) - body to channel cap
Qbc0 = V(b,c0)*Cbc;
I(b,c0)<+ddt(Qbc0);

// I(g,c0) - gate to channel variable cap
Qgc0 = V(g,c0)*Cgc*(t_gap - t_chan)/(Pos(mbr,z) - t_chan);
I(g,c0)<+ddt(Qgc0);

// I(d0,g), I(s0,g) - drain/source to gate cap
Qdg0 = V(d0,g)*Cgds;
Qsg0 = V(s0,g)*Cgds;
I(d0,g)<+ddt(Qdg0);
I(s0,g)<+ddt(Qsg0);

// I(b,d0), I(b,s0) - body to drain/source variable cap
Qbd0 = V(b,d0)*Cbds*(t_gap + t_sp/K_sp)/(Pos(mbr,z) + t_sp/K_sp);
Qbs0 = V(b,s0)*Cbds*(t_gap + t_sp/K_sp)/(Pos(mbr,z) + t_sp/K_sp);
I(b,d0)<+ddt(Qbd0);
I(b,s0)<+ddt(Qbs0);

// I(d0,c0), I(s0,c0) - channel to drain/source variable contact resistance
I(d0,c0)<+V(d0,c0)/
    (Rcont + Rair * smoothstep(Pos(mbr,z) - t_cont, Rturnonsharp));
I(s0,c0)<+V(s0,c0)/
    (Rcont + Rair * smoothstep(Pos(mbr,z) - t_cont, Rturnonsharp));

// I(b,c1) - body to channel cap
Qbc1 = V(b,c1)*Cbc;
I(b,c1)<+ddt(Qbc1);

// I(g,c1) - gate to channel variable cap
Qgc1 = V(g,c1)*Cgc*(t_gap - t_chan)/(Pos(mbr,z) - t_chan);
I(g,c1)<+ddt(Qgc1);

// I(d1,g), I(s1,g) - drain/source to gate cap
Qdg1 = V(d1,g)*Cgds;
Qsg1 = V(s1,g)*Cgds;
I(d1,g)<+ddt(Qdg1);
I(s1,g)<+ddt(Qsg1);

// I(b,d1), I(b,s1) - body to drain/source variable cap
Qbd1 = V(b,d1)*Cbds*(t_gap + t_sp/K_sp)/(Pos(mbr,z) + t_sp/K_sp);
Qbs1 = V(b,s1)*Cbds*(t_gap + t_sp/K_sp)/(Pos(mbr,z) + t_sp/K_sp);
I(b,d1)<+ddt(Qbd1);
I(b,s1)<+ddt(Qbs1);

// I(d1,c1), I(s1,c1) - channel to drain/source variable contact resistance
I(d1,c1)<+V(d1,c1)/
    (Rcont + Rair * smoothstep(Pos(mbr,z) - t_cont, Rturnonsharp));
I(s1,c1)<+V(s1,c1)/
    (Rcont + Rair * smoothstep(Pos(mbr,z) - t_cont, Rturnonsharp));

// ===========================================
// F(mbr,z) - Normalized Mechanical Equations
// ===========================================
// Set mbr to mechanical ground
Pos(mbr) <+ t_gap;

// Force Balance Equation
Ftot = meff * ddt(ddt(Pos(z)));
Fdamp = meff * w0/Qf * ddt(Pos(z));
Fk = meff * w0*w0 * Pos(z);
Fel = Qgb * V(g,b) / (2 * (Pos(mbr,z) + t_sp/K_sp));
Fcont = cturnonval*limexp(-cturnonsharp*(Pos(mbr,z) - t_cont));
F(mbr,z) <+ Ftot + Fdamp + Fk - Fel + Fcont;

// DEBUG
$debug("\nBEGIN");
$debug("P_EPS0 = %e", P_EPS0);
$debug("Vgate = %e", V(g));
$debug("Pos(z) = %e", Pos(z));
$debug("Pos(mbr,z) = %e", Pos(mbr,z));
$debug("Ftot = %e", Ftot);
$debug("Fdamp = %e", Fdamp);
$debug("Fk = %e", Fk);
$debug("Fel = %e", Fel);
$debug("Fcont = %e", Fcont);
$debug("END");

end
endmodule
